# Ansys Electronics Desktop project, version 2023.2
materials:
  vacuum: permittivity=1

design HFSSDesign1 (HFSS, HFSS Terminal Network, model units mm)
geometry:
  Dipole_Antenna1 = component(Dipole_Antenna, 3D_Component_File_Path=<syslib>/3DComponents/HFSS/Antennas/Dipole/Dipole_Antenna_DM.a3dcomp, dipole_length=5.62cm, wire_rad=0.094cm, port_gap=0.094cm)
  arm1, arm1_1 [pec] = part_of(Dipole_Antenna1)
  port1 [vacuum] = part_of(Dipole_Antenna1)
  RadiatingSurface [vacuum] = region(absolute_offset=100mm on all sides)
boundaries and excitations:
  Open1: Radiation Objects=RadiatingSurface
  Dipole_Antenna1_p1: Lumped Port Objects=port1 LumpedPortType=Modal Modes{Mode1{IntLine{(0, 0, -0.47) -> (0, 0, 0.47)} CharImp=Zpi RenormImp=50ohm}} Impedance=50ohm
setups:
  Setup1: HfssDrivenAuto AutoSolverSetting=Balanced SaveAnyFields=false Type=Interpolating
    sweep Sweep: 0GHz to 10GHz, 501 points;
source amplitudes:
  Dipole_Antenna1_p1:1: 1V 0deg
radiation setups:
  3D: Infinite Sphere Theta=0deg..180deg step 2deg Phi=-180deg..180deg step 2deg
  Elevation: Infinite Sphere Theta=-180deg..180deg step 1deg Phi=0deg..90deg step 90deg
  Azimuth: Infinite Sphere Theta=90deg..90deg step 0deg Phi=-180deg..180deg step 1deg
