# Ansys Electronics Desktop project, version 2023.2
materials:
  aluminum2: permeability=1.000021 conductivity=20000000
  vacuum: permittivity=1
  pec: conductivity=1e+30

design System (HFSS, HFSS Hybrid Modal Network, model units mm)
options: Save_Adaptive_support_files
variables:
  Offset = 0mm
  MSND = 5deg
  MSD = 10mm
geometry:
  Horn1 = component(Horn, 3D_Component_File_Path=<userlib>/3DComponents/Horn.a3dcomp, Frequency=5GHz, R_Horn=20mm)
  Horn_1 [vacuum] = part_of(Horn1)
  pCap [pec] = part_of(Horn1)
  Horn_RadVol [vacuum] = part_of(Horn1)
  ParabolicDish1 = component(ParabolicDish, 3D_Component_File_Path=<userlib>/3DComponents/ParabolicDish.a3dcomp, focal=800mm, Diameter=2000mm)
  parabolic_reflector [aluminum2] = part_of(ParabolicDish1)
  Horn1.move(TranslateVectorX=0mm TranslateVectorY=Offset TranslateVectorZ=0mm)
boundaries and excitations:
  Horn1_Horn: Perfect E Faces=Horn_1.face(at (0, 149.917, -20), at (0, 59.9585, 46.7169))
  Horn1_Rad1: FE-BI Objects=Horn_RadVol UseAdaptiveIE
  ParabolicDish1_IE1: Hybrid Region Objects=parabolic_reflector Type=IE
  ParabolicDish1_Dish: Perfect E Objects=parabolic_reflector
  Horn1_1: Wave Port Faces=Horn_1.face(at (0, 179.917, 0)) WavePortType=Modal NumModes=2 UseLineModeAlignment Modes{Mode1{IntLine{(0, 179.9169832, -20) -> (0, 179.9169832, 20)} CharImp=Zpi} Mode2{IntLine{(-20, 179.9169832, 0) -> (20, 179.9169832, 0)} CharImp=Zpi}}
mesh:
  Horn1_Length1: LengthBased Faces=Horn_1.face(at (0, 149.917, -20), at (0, 59.9585, 46.7169)) NumMaxElem=10000
  initial mesh: GlobalSurfApproximation{CurvedSurfaceApproxChoice=UseSlider SliderMeshSettings=4} GlobalCurvilinear{Apply} MeshMethod=AnsoftClassic
setups:
  5GHz: HfssDriven Frequency=5GHz MaxDeltaS=0.01 MaximumPasses=6 MinimumPasses=1 MinimumConvergedPasses=1 PercentRefinement=30 BasisOrder=1 PortAccuracy=0.1 DrivenSolverType="Domain Decomposition" IterativeResidual=1e-06 DDMSolverResidual=0.0001 IESolverType=ACA
source amplitudes:
  Horn1_1:1: 1W 0deg
  Horn1_1:2: 1W 90deg
optimetrics:
  ParametricSetup1: Parametric Sim._Setups=[5GHz]
    sweep Offset: LIN -100mm 100mm 20mm
radiation setups:
  XY: Infinite Sphere Theta=90deg..90deg step 0deg Phi=-180deg..180deg step 0.2deg
  3D: Infinite Sphere Theta=0deg..180deg step 1deg Phi=-180deg..180deg step 1deg
field plots:
  Mag_E1: E Field over Horn_1.face(at (0, 59.9585, 46.7169), at (0, 149.917, -20)) on 5GHz : LastAdaptive at Freq=5GHz Phase=0deg
reports:
  Radiation Pattern 1: dB(GainTotal) vs Phi on 5GHz : LastAdaptive, XY [Theta=all Freq=5GHz Offset=all]
  3D Polar Plot 1: dB(GainTotal) vs Phi, Theta on 5GHz : LastAdaptive, 3D [Freq=5GHz Offset=-100mm]
