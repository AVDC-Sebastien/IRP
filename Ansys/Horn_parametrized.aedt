# Ansys Electronics Desktop project, version 2023.2
materials:
  vacuum: permittivity=1
  perfect conductor: conductivity=1e+30

design HFSSDesign1 (HFSS, HFSS Hybrid Modal Network, model units mm)
variables:
  Horn_length = 130mm
  a = 23mm
  b = 10mm
  WG_lenght = 25mm
  PlaneA = (2.65*25.4) mm
  PlaneB = (1.95*25.4) mm
  Wall_thickness = (25.4*0.05) mm
  rad_dist = (25.4*0.4) mm
geometry:
  Horn_air [vacuum] = box(corner=(Horn_length, -a/2, -b/2), size=(WG_lenght, a, b))
  Rectangle1 = rectangle(corner=(0mm, -PlaneA/2, -PlaneB/2), y_size=PlaneA, z_size=PlaneB)
  Horn_ObjectFromFace1 = object_from(Horn_air.face(-x))
  Horn_ObjectFromFace1.connect(Rectangle1)
  Horn_air.unite(Horn_ObjectFromFace1)
  Horn_shell [perfect conductor], Horn_ObjectFromFace3..Horn_ObjectFromFace10 = object_from(Horn_air.face(+z, -z, -y, +y, +x, #58, #59, #60, #61))
  Horn_shell.unite(Horn_ObjectFromFace3..Horn_ObjectFromFace10)
  Horn_shell.thicken(Wall_thickness)
  Region [vacuum] = region(absolute_offset=rad_dist on all sides)
  wport = rectangle(corner=(Horn_length +WG_lenght, -a/2, -b/2), y_size=a, z_size=b)
boundaries and excitations:
  FE-BI1: FE-BI Objects=Region UseAdaptiveIE
  1: Wave Port Objects=wport WavePortType=Modal NumModes=1 Modes{Mode1{CharImp=Zpi}}
setups:
  Setup1: HfssDrivenAuto AutoSolverSetting=Balanced SaveAnyFields=false Type=Interpolating
    sweep Sweep: 0GHz to 10GHz, 501 points;
source amplitudes:
  1:1: 1W 0deg
radiation setups:
  Infinite Sphere1: Infinite Sphere Theta=0deg..180deg step 2deg Phi=0deg..360deg step 2deg
reports:
  S Parameter Plot 1: dB(S(1,1)) vs Freq, Horn_length on Setup1 : LastAdaptive
  S Parameter Plot 2: dB(S(1,1)) vs Freq, Horn_length on Setup1 : Sweep
