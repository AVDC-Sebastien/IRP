# Ansys Electronics Desktop project, version 2023.2
materials:
  aluminum: permeability=1.000021 conductivity=38000000
  pec: conductivity=1e+30
  vacuum: permittivity=1

design Horn_param (HFSS, HFSS Hybrid Modal Network, model units mm)
options: Save_Adaptive_support_files
variables:
  fc = 30GHz  # Central Frequency
  lc = 1e3*c0/fc mm  # Lambda @fc
  w = 0.02  # Metal Width
  rA = 0.51  # Input WG Radius
  hA = 0.5  # Input WG Axial Length
  rB = 0.687  # Section B Radius
  hB = 0.585  # Section B Axial Length
  rC = 0.805  # Section C Radius
  hC = 0.661  # Section C Axial Length
  rD = 0.822  # Section D Radius
  hD = 2.3  # Section D Axial Length
  PC = -0.073  # Phase Center Position from Aperture; optimise -1..1
geometry:
  WA_vacuum [vacuum] = cylinder(axis=Z, base_centre=(0mm, 0mm, 0mm), radius=rA*lc, height=hA*lc)
  WB_vacuum = cone(axis=Z, base_centre=(0mm, 0mm, hA*lc), bottom_radius=rA*lc, top_radius=rB*lc, height=hB*lc)
  WA_metal [aluminum] = cylinder(axis=Z, base_centre=(0mm, 0mm, 0mm), radius=rA*lc+w*lc, height=hA*lc)
  WB_metal = cone(axis=Z, base_centre=(0mm, 0mm, hA*lc), bottom_radius=rA*lc+w*lc, top_radius=rB*lc+w*lc, height=hB*lc)
  WC_vacuum = cylinder(axis=Z, base_centre=(0mm, 0mm, (hA+hB)*lc), radius=rC*lc, height=hC*lc)
  WC_metal = cylinder(axis=Z, base_centre=(0mm, 0mm, (hA+hB)*lc), radius=rC*lc+w*lc, height=hC*lc)
  WC_metal1 = cylinder(axis=Z, base_centre=(0mm, 0mm, (hA+hB)*lc), radius=rC*lc+w*lc, height=-lc/20)
  WC_metal.unite(WC_metal1)
  WD_vacuum = cone(axis=Z, base_centre=(0mm, 0mm, (hA+hB+hc)*lc), bottom_radius=rC*lc, top_radius=rD*lc, height=hD*lc)
  WD_metal = cone(axis=Z, base_centre=(0mm, 0mm, (hA+hB+hc)*lc), bottom_radius=rC*lc+w*lc, top_radius=rD*lc+w*lc, height=hD*lc)
  WA_metal.unite(WB_metal, WC_metal, WD_metal)
  WA_vacuum.unite(WB_vacuum, WC_vacuum, WD_vacuum)
  WA_vacuum_1 = WA_vacuum.copy()
  WA_metal.subtract(WA_vacuum_1)
  Cap [pec] = cylinder(axis=Z, base_centre=(0mm, 0mm, 0mm), radius=rA*lc+w*lc, height=-lc/20)
  coordinate_system Aperture_PC = origin=(0mm, 0mm, (hA+hB+hC+hD)*lc-PC*lc) x=(1mm, 0mm, 0mm) y=(0mm, 1mm, 0mm)
  Region [vacuum] = region(absolute_offset=1.18mm on all sides)
boundaries and excitations:
  Open1: FE-BI Faces=Region.face(all 6) UseAdaptiveIE
  1: Wave Port Faces=WA_vacuum.face(-z end) WavePortType=Modal NumModes=2 Modes{Mode1{IntLine{(-5.096471786, 0, 0) -> (5.096471786, 0, 0)} CharImp=Zwave} Mode2{IntLine{(0, -5.096471786, 0) -> (0, 5.096471786, 0)} CharImp=Zwave}} UseAnalyticAlignment AnalyticULine{(-5.096471786, 0, 0) -> (5.096471786, 0, 0)}
mesh:
  initial mesh: GlobalSurfApproximation{CurvedSurfaceApproxChoice=UseSlider SliderMeshSettings=6} GlobalCurvilinear{Apply} MeshMethod=AnsoftClassic
setups:
  HigherAccuracy: HfssDrivenAuto AutoSolverSetting="Higher Accuracy" Type=Interpolating
    sweep Sweep: 28GHz to 32GHz step 0.02GHz;
source amplitudes:
  1:1: 1W 0deg
  1:2: 0W 90deg
radiation setups:
  3D: Infinite Sphere Theta=-180deg..180deg step 1deg Phi=0deg..180deg step 1deg CoordSystem=Aperture_PC
  Cut0: Infinite Sphere Theta=-180deg..180deg step 1deg Phi=0deg..0deg step 0deg CoordSystem=Aperture_PC
  Cut45: Infinite Sphere Theta=-180deg..180deg step 1deg Phi=45deg..45deg step 0deg CoordSystem=Aperture_PC
  Cut90: Infinite Sphere Theta=-180deg..180deg step 1deg Phi=90deg..90deg step 0deg CoordSystem=Aperture_PC
field plots:
  E-Field: E Field over WA_vacuum.face(-z end) Region.face(+z) on HigherAccuracy : LastAdaptive at Freq=30GHz Phase=0deg
reports:
  S Parameter: dB(S(1:1,1:1)) vs Freq on HigherAccuracy : Sweep
  Directivity: dB(DirL3X) vs Theta on HigherAccuracy : LastAdaptive, Cut0 [Phi=all Freq=all]; dB(DirL3X) vs Theta on HigherAccuracy : LastAdaptive, Cut90 [Phi=all Freq=all]; dB(DirL3X), dB(DirL3Y) vs Theta on HigherAccuracy : LastAdaptive, Cut45 [Phi=all Freq=all]
  10dB_BeamWidth: dB10normalize(DirL3X) vs Theta on HigherAccuracy : LastAdaptive, Cut0 [Phi=all Freq=all]; dB10normalize(DirL3X) vs Theta on HigherAccuracy : LastAdaptive, Cut90 [Phi=all Freq=all]; markers MY1 at y=-10
  Phase at PhaseCenter: cang_deg(rEL3X) vs Theta on HigherAccuracy : LastAdaptive, Cut0 [Phi=all Freq=all]; cang_deg(rEL3X) vs Theta on HigherAccuracy : LastAdaptive, Cut90 [Phi=all Freq=all]
  3D Directivity: dB(DirL3X) vs Phi, Theta on HigherAccuracy : LastAdaptive, 3D [Freq=30GHz]
  Directivity Plot 1: dB(DirTotal) vs Phi, Theta on HigherAccuracy : LastAdaptive, 3D [Freq=30GHz]
  Directivity Plot 2: dB(DirTotal) vs Phi, Theta on HigherAccuracy : LastAdaptive, 3D [Freq=30GHz]
